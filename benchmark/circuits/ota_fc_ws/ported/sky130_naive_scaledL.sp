* ota_fc_ws: NAIVE PORT (scaledL) of source_180n.sp to Sky130 1.8 V LVT devices.
* Generated by benchmark/naive_port.py: device swap + length rule only; topology, m, bulks,
* R/C values unchanged. Sizes in um (Sky130 models use .option scale=1u).
* Device changes:
*   MN12: tsmc18dN W=6.66 L=0.36 -> nfet_01v8_lvt W=5.55 L=0.3 m=1
*   MN11: tsmc18dN W=6.66 L=0.36 -> nfet_01v8_lvt W=5.55 L=0.3 m=1
*   MN10: tsmc18dN W=6.66 L=0.36 -> nfet_01v8_lvt W=5.55 L=0.3 m=1
*   MN9: tsmc18dN W=6.66 L=0.36 -> nfet_01v8_lvt W=5.55 L=0.3 m=1
*   MN8: tsmc18dN W=6.66 L=3.33 -> nfet_01v8_lvt W=5.55 L=2.775 m=1
*   MN7: tsmc18dN W=6.66 L=0.36 -> nfet_01v8_lvt W=5.55 L=0.3 m=1
*   MN6: tsmc18dN W=6.66 L=0.36 -> nfet_01v8_lvt W=5.55 L=0.3 m=1
*   MN4: tsmc18dN W=6.66 L=0.36 -> nfet_01v8_lvt W=5.55 L=0.3 m=1
*   MP11: tsmc18dP W=12.195 L=0.36 -> pfet_01v8_lvt W=10.16 L=0.35 (clamped to Lmin) m=1
*   MP10: tsmc18dP W=12.195 L=0.36 -> pfet_01v8_lvt W=10.16 L=0.35 (clamped to Lmin) m=1
*   MP7: tsmc18dP W=12.195 L=0.36 -> pfet_01v8_lvt W=10.16 L=0.35 (clamped to Lmin) m=1
*   MP6: tsmc18dP W=12.195 L=0.36 -> pfet_01v8_lvt W=10.16 L=0.35 (clamped to Lmin) m=1
*   MP4: tsmc18dP W=12.195 L=4 -> pfet_01v8_lvt W=10.16 L=3.335 m=1
*   MP3: tsmc18dP W=12.195 L=0.36 -> pfet_01v8_lvt W=10.16 L=0.35 (clamped to Lmin) m=1
*   MP2: tsmc18dP W=12.195 L=0.36 -> pfet_01v8_lvt W=10.16 L=0.35 (clamped to Lmin) m=1
*   MN6: tsmc18dN W=6.66 L=0.36 -> nfet_01v8_lvt W=5.55 L=0.3 m=1
*   MN0: tsmc18dN W=6.66 L=0.36 -> nfet_01v8_lvt W=5.55 L=0.3 m=1
*   MN2: tsmc18dN W=6.66 L=0.36 -> nfet_01v8_lvt W=5.55 L=0.3 m=1
*   MN9: tsmc18dN W=6.66 L=0.36 -> nfet_01v8_lvt W=5.55 L=0.3 m=1
*   MN1: tsmc18dN W=6.66 L=0.36 -> nfet_01v8_lvt W=5.55 L=0.3 m=1
*   MN8: tsmc18dN W=6.66 L=0.36 -> nfet_01v8_lvt W=5.55 L=0.3 m=1
*   MN4: tsmc18dN W=6.66 L=0.36 -> nfet_01v8_lvt W=5.55 L=0.3 m=1
*   MN3: tsmc18dN W=6.66 L=0.36 -> nfet_01v8_lvt W=5.55 L=0.3 m=1
*   MN5: tsmc18dN W=6.66 L=0.36 -> nfet_01v8_lvt W=5.55 L=0.3 m=1
*   MN7: tsmc18dN W=6.66 L=0.36 -> nfet_01v8_lvt W=5.55 L=0.3 m=1
*   MP4: tsmc18dP W=12.195 L=0.36 -> pfet_01v8_lvt W=10.16 L=0.35 (clamped to Lmin) m=1
*   MP5: tsmc18dP W=12.195 L=0.36 -> pfet_01v8_lvt W=10.16 L=0.35 (clamped to Lmin) m=1
*   MP1: tsmc18dP W=12.195 L=0.36 -> pfet_01v8_lvt W=10.16 L=0.35 (clamped to Lmin) m=1
*   MP3: tsmc18dP W=12.195 L=0.36 -> pfet_01v8_lvt W=10.16 L=0.35 (clamped to Lmin) m=1
*   MP2: tsmc18dP W=12.195 L=0.36 -> pfet_01v8_lvt W=10.16 L=0.35 (clamped to Lmin) m=1
*   MP0: tsmc18dP W=12.195 L=0.36 -> pfet_01v8_lvt W=10.16 L=0.35 (clamped to Lmin) m=1
* ota_fc_ws: DUT built from ngspice-180n-testbenches/tb_OTA_Folded_Cascode_ac/tb_OTA_Folded_Cascode_ac.cir (advisor's design, wide-swing bias, P4 L = 4 um)
* Generated by benchmark/import_180n_sources.py; subcircuits copied verbatim.
* Folded-cascode OTA (advisor's netlist).
* Ports: iref inp inn out.
.subckt Cascode_Bias_WS Iin Vbias_1 Vbias_2 Vbias_3 Vbias_4
  XMN12 Vbias_2 Vbias_2 net1 0 sky130_fd_pr__nfet_01v8_lvt W=5.55 L=0.3 nf=1 ad=1.6095 as=1.6095 pd=11.68 ps=11.68 m=1
  XMN11 Vbias_1 Vbias_1 net2 0 sky130_fd_pr__nfet_01v8_lvt W=5.55 L=0.3 nf=1 ad=1.6095 as=1.6095 pd=11.68 ps=11.68 m=1
  XMN10 net10 Vbias_4 0 0 sky130_fd_pr__nfet_01v8_lvt W=5.55 L=0.3 nf=1 ad=1.6095 as=1.6095 pd=11.68 ps=11.68 m=1
  XMN9 Vbias_4 Vbias_3 net10 0 sky130_fd_pr__nfet_01v8_lvt W=5.55 L=0.3 nf=1 ad=1.6095 as=1.6095 pd=11.68 ps=11.68 m=1
  XMN8 Vbias_3 Vbias_3 0 0 sky130_fd_pr__nfet_01v8_lvt W=5.55 L=2.775 nf=1 ad=1.6095 as=1.6095 pd=11.68 ps=11.68 m=1
  XMN7 net2 Iin 0 0 sky130_fd_pr__nfet_01v8_lvt W=5.55 L=0.3 nf=1 ad=1.6095 as=1.6095 pd=11.68 ps=11.68 m=1
  XMN6 net1 Iin 0 0 sky130_fd_pr__nfet_01v8_lvt W=5.55 L=0.3 nf=1 ad=1.6095 as=1.6095 pd=11.68 ps=11.68 m=1
  XMN4 Iin Iin 0 0 sky130_fd_pr__nfet_01v8_lvt W=5.55 L=0.3 nf=1 ad=1.6095 as=1.6095 pd=11.68 ps=11.68 m=1
  XMP11 net6 Vbias_1 vdd vdd sky130_fd_pr__pfet_01v8_lvt W=10.16 L=0.35 nf=1 ad=2.9464 as=2.9464 pd=20.9 ps=20.9 m=1
  XMP10 Vbias_4 Vbias_2 net6 vdd sky130_fd_pr__pfet_01v8_lvt W=10.16 L=0.35 nf=1 ad=2.9464 as=2.9464 pd=20.9 ps=20.9 m=1
  XMP7 net5 Vbias_1 vdd vdd sky130_fd_pr__pfet_01v8_lvt W=10.16 L=0.35 nf=1 ad=2.9464 as=2.9464 pd=20.9 ps=20.9 m=1
  XMP6 Vbias_3 Vbias_2 net5 vdd sky130_fd_pr__pfet_01v8_lvt W=10.16 L=0.35 nf=1 ad=2.9464 as=2.9464 pd=20.9 ps=20.9 m=1
  XMP4 Vbias_2 Vbias_2 vdd vdd sky130_fd_pr__pfet_01v8_lvt W=10.16 L=3.335 nf=1 ad=2.9464 as=2.9464 pd=20.9 ps=20.9 m=1
  XMP3 net13 Vbias_1 vdd vdd sky130_fd_pr__pfet_01v8_lvt W=10.16 L=0.35 nf=1 ad=2.9464 as=2.9464 pd=20.9 ps=20.9 m=1
  XMP2 Vbias_1 Vbias_2 net13 vdd sky130_fd_pr__pfet_01v8_lvt W=10.16 L=0.35 nf=1 ad=2.9464 as=2.9464 pd=20.9 ps=20.9 m=1
.ends Cascode_Bias_WS
.subckt OTA_Folded_Cascode Vbias_2 Vbias_3 Vbias_4 vm vout vp
  XMN6 net1 Vbias_3 net018 0 sky130_fd_pr__nfet_01v8_lvt W=5.55 L=0.3 nf=1 ad=1.6095 as=1.6095 pd=11.68 ps=11.68 m=1
  XMN0 net08 Vbias_3 net020 0 sky130_fd_pr__nfet_01v8_lvt W=5.55 L=0.3 nf=1 ad=1.6095 as=1.6095 pd=11.68 ps=11.68 m=1
  XMN2 net010 vp net08 0 sky130_fd_pr__nfet_01v8_lvt W=5.55 L=0.3 nf=1 ad=1.6095 as=1.6095 pd=11.68 ps=11.68 m=1
  XMN9 vout Vbias_3 net017 0 sky130_fd_pr__nfet_01v8_lvt W=5.55 L=0.3 nf=1 ad=1.6095 as=1.6095 pd=11.68 ps=11.68 m=1
  XMN1 net016 vm net08 0 sky130_fd_pr__nfet_01v8_lvt W=5.55 L=0.3 nf=1 ad=1.6095 as=1.6095 pd=11.68 ps=11.68 m=1
  XMN8 net017 Vbias_4 0 0 sky130_fd_pr__nfet_01v8_lvt W=5.55 L=0.3 nf=1 ad=1.6095 as=1.6095 pd=11.68 ps=11.68 m=1
  XMN4 net019 Vbias_4 0 0 sky130_fd_pr__nfet_01v8_lvt W=5.55 L=0.3 nf=1 ad=1.6095 as=1.6095 pd=11.68 ps=11.68 m=1
  XMN3 net020 Vbias_4 0 0 sky130_fd_pr__nfet_01v8_lvt W=5.55 L=0.3 nf=1 ad=1.6095 as=1.6095 pd=11.68 ps=11.68 m=1
  XMN5 net08 Vbias_3 net019 0 sky130_fd_pr__nfet_01v8_lvt W=5.55 L=0.3 nf=1 ad=1.6095 as=1.6095 pd=11.68 ps=11.68 m=1
  XMN7 net018 Vbias_4 0 0 sky130_fd_pr__nfet_01v8_lvt W=5.55 L=0.3 nf=1 ad=1.6095 as=1.6095 pd=11.68 ps=11.68 m=1
  XMP4 net1 Vbias_2 net010 vdd sky130_fd_pr__pfet_01v8_lvt W=10.16 L=0.35 nf=1 ad=2.9464 as=2.9464 pd=20.9 ps=20.9 m=1
  XMP5 vout Vbias_2 net016 vdd sky130_fd_pr__pfet_01v8_lvt W=10.16 L=0.35 nf=1 ad=2.9464 as=2.9464 pd=20.9 ps=20.9 m=1
  XMP1 net010 net1 vdd vdd sky130_fd_pr__pfet_01v8_lvt W=10.16 L=0.35 nf=1 ad=2.9464 as=2.9464 pd=20.9 ps=20.9 m=1
  XMP3 net016 net1 vdd vdd sky130_fd_pr__pfet_01v8_lvt W=10.16 L=0.35 nf=1 ad=2.9464 as=2.9464 pd=20.9 ps=20.9 m=1
  XMP2 net016 net1 vdd vdd sky130_fd_pr__pfet_01v8_lvt W=10.16 L=0.35 nf=1 ad=2.9464 as=2.9464 pd=20.9 ps=20.9 m=1
  XMP0 net010 net1 vdd vdd sky130_fd_pr__pfet_01v8_lvt W=10.16 L=0.35 nf=1 ad=2.9464 as=2.9464 pd=20.9 ps=20.9 m=1
.ends OTA_Folded_Cascode
.subckt dut iref inp inn out
XI0 iref vb1 vb2 vb3 vb4 Cascode_Bias_WS
XI1 vb2 vb3 vb4 inn out inp OTA_Folded_Cascode
.ends dut
