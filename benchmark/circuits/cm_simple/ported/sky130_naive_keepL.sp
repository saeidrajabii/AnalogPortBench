* cm_simple: NAIVE PORT (keepL) of source_180n.sp to Sky130 1.8 V LVT devices.
* Generated by benchmark/naive_port.py: device swap + length rule only; topology, m, bulks,
* R/C values unchanged. Sizes in um (Sky130 models use .option scale=1u).
* Device changes:
*   MN1: tsmc18dN W=6.66 L=0.36 -> nfet_01v8_lvt W=6.66 L=0.36 m=1
*   MN0: tsmc18dN W=6.66 L=0.36 -> nfet_01v8_lvt W=6.66 L=0.36 m=1
* cm_simple: DUT extracted from ngspice-180n-testbenches/tb_CM_basic/tb_CM_basic.cir
* Ports: in (Iref is forced into it), out (current output).
.subckt CM_basic in out
  XMN1 in in 0 0 sky130_fd_pr__nfet_01v8_lvt W=6.66 L=0.36 nf=1 ad=1.9314 as=1.9314 pd=13.9 ps=13.9 m=1
  XMN0 out in 0 0 sky130_fd_pr__nfet_01v8_lvt W=6.66 L=0.36 nf=1 ad=1.9314 as=1.9314 pd=13.9 ps=13.9 m=1
.ends CM_basic
.subckt dut in out
XI0 in out CM_basic
.ends dut
