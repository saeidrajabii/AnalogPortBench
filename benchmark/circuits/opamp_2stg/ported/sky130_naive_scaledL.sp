* opamp_2stg: NAIVE PORT (scaledL) of source_180n.sp to Sky130 1.8 V LVT devices.
* Generated by benchmark/naive_port.py: device swap + length rule only; topology, m, bulks,
* R/C values unchanged. Sizes in um (Sky130 models use .option scale=1u).
* Device changes:
*   MN1: tsmc18dN W=6.66 L=0.36 -> nfet_01v8_lvt W=5.55 L=0.3 m=1
*   MN0: tsmc18dN W=6.66 L=0.36 -> nfet_01v8_lvt W=5.55 L=0.3 m=1
*   MN3: tsmc18dN W=6.66 L=0.36 -> nfet_01v8_lvt W=5.55 L=0.3 m=1
*   MN2: tsmc18dN W=6.66 L=0.36 -> nfet_01v8_lvt W=5.55 L=0.3 m=1
*   MP1: tsmc18dP W=12.195 L=0.36 -> pfet_01v8_lvt W=10.16 L=0.35 (clamped to Lmin) m=1
*   MP0: tsmc18dP W=12.195 L=0.36 -> pfet_01v8_lvt W=10.16 L=0.35 (clamped to Lmin) m=1
*   MP2: tsmc18dP W=12.195 L=0.36 -> pfet_01v8_lvt W=10.16 L=0.35 (clamped to Lmin) m=3
*   MP0: tsmc18dP W=12.195 L=0.36 -> pfet_01v8_lvt W=10.16 L=0.35 (clamped to Lmin) m=1
*   MP1: tsmc18dP W=12.195 L=0.36 -> pfet_01v8_lvt W=10.16 L=0.35 (clamped to Lmin) m=1
*   MN5: tsmc18dN W=6.66 L=0.36 -> nfet_01v8_lvt W=5.55 L=0.3 m=3
*   MN4: tsmc18dN W=6.66 L=0.36 -> nfet_01v8_lvt W=5.55 L=0.3 m=3
*   MN2: tsmc18dN W=6.66 L=0.36 -> nfet_01v8_lvt W=5.55 L=0.3 m=1
*   MN1: tsmc18dN W=6.66 L=0.36 -> nfet_01v8_lvt W=5.55 L=0.3 m=1
*   MN3: tsmc18dN W=6.66 L=0.36 -> nfet_01v8_lvt W=5.55 L=0.3 m=2
*   MN0: tsmc18dN W=6.66 L=0.36 -> nfet_01v8_lvt W=5.55 L=0.3 m=2
* opamp_2stg: DUT extracted from ngspice-180n-testbenches/tb_Opamp_2stg_stb/tb_Opamp_2stg_stb.cir
* Ports: iref (20 uA bias current in), inp, inn, out.
.subckt Cascode_Bias Iin Vbias_1 Vbias_2 Vbias_3 Vbias_4
  XMN1 Vbias_4 Vbias_4 0 0 sky130_fd_pr__nfet_01v8_lvt W=5.55 L=0.3 nf=1 ad=1.6095 as=1.6095 pd=11.68 ps=11.68 m=1
  XMN0 net4 Vbias_4 0 0 sky130_fd_pr__nfet_01v8_lvt W=5.55 L=0.3 nf=1 ad=1.6095 as=1.6095 pd=11.68 ps=11.68 m=1
  XMN3 Vbias_3 Vbias_3 Vbias_4 0 sky130_fd_pr__nfet_01v8_lvt W=5.55 L=0.3 nf=1 ad=1.6095 as=1.6095 pd=11.68 ps=11.68 m=1
  XMN2 Vbias_2 Vbias_3 net4 0 sky130_fd_pr__nfet_01v8_lvt W=5.55 L=0.3 nf=1 ad=1.6095 as=1.6095 pd=11.68 ps=11.68 m=1
  XMP1 Vbias_1 Vbias_1 vdd vdd sky130_fd_pr__pfet_01v8_lvt W=10.16 L=0.35 nf=1 ad=2.9464 as=2.9464 pd=20.9 ps=20.9 m=1
  XMP0 Vbias_2 Vbias_2 Vbias_1 vdd sky130_fd_pr__pfet_01v8_lvt W=10.16 L=0.35 nf=1 ad=2.9464 as=2.9464 pd=20.9 ps=20.9 m=1
  RR0 Iin Vbias_3 1
.ends Cascode_Bias
.subckt Opamp_2stg Vbias_3 Vbias_4 vm vout vp
  CC0 net012 vout 500f m=1
  RR0 net08 net012 3k m=1
  XMP2 vout net08 vdd vdd sky130_fd_pr__pfet_01v8_lvt W=10.16 L=0.35 nf=1 ad=2.9464 as=2.9464 pd=20.9 ps=20.9 m=3
  XMP0 net08 net9 vdd vdd sky130_fd_pr__pfet_01v8_lvt W=10.16 L=0.35 nf=1 ad=2.9464 as=2.9464 pd=20.9 ps=20.9 m=1
  XMP1 net9 net9 vdd vdd sky130_fd_pr__pfet_01v8_lvt W=10.16 L=0.35 nf=1 ad=2.9464 as=2.9464 pd=20.9 ps=20.9 m=1
  XMN5 vout Vbias_3 net1 0 sky130_fd_pr__nfet_01v8_lvt W=5.55 L=0.3 nf=1 ad=1.6095 as=1.6095 pd=11.68 ps=11.68 m=3
  XMN4 net1 Vbias_4 0 0 sky130_fd_pr__nfet_01v8_lvt W=5.55 L=0.3 nf=1 ad=1.6095 as=1.6095 pd=11.68 ps=11.68 m=3
  XMN2 net9 vm net10 0 sky130_fd_pr__nfet_01v8_lvt W=5.55 L=0.3 nf=1 ad=1.6095 as=1.6095 pd=11.68 ps=11.68 m=1
  XMN1 net08 vp net10 0 sky130_fd_pr__nfet_01v8_lvt W=5.55 L=0.3 nf=1 ad=1.6095 as=1.6095 pd=11.68 ps=11.68 m=1
  XMN3 net12 Vbias_4 0 0 sky130_fd_pr__nfet_01v8_lvt W=5.55 L=0.3 nf=1 ad=1.6095 as=1.6095 pd=11.68 ps=11.68 m=2
  XMN0 net10 Vbias_3 net12 0 sky130_fd_pr__nfet_01v8_lvt W=5.55 L=0.3 nf=1 ad=1.6095 as=1.6095 pd=11.68 ps=11.68 m=2
.ends Opamp_2stg
.subckt dut iref inp inn out
XI0 iref vb1 vb2 vb3 vb4 Cascode_Bias
XI1 vb3 vb4 inn out inp Opamp_2stg
.ends dut
