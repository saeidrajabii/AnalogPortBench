* ota_tele_ws: DUT built from ngspice-180n-testbenches/tb_OTA_Telescopic_ac/tb_OTA_Telescopic_ac.cir (advisor's design, wide-swing bias, P4 L = 4 um)
* Technology: TSMC 0.18 um (tsmc18dN / tsmc18dP, BSIM3), VDD = 1.8 V on global node vdd, ground = 0.
* Generated by benchmark/import_180n_sources.py; subcircuits copied verbatim.
* Single-ended telescopic OTA with replica-biased cascodes.
* Ports: iref inp inn out.
.subckt Cascode_Bias_WS Iin Vbias_1 Vbias_2 Vbias_3 Vbias_4
  MN12 Vbias_2 Vbias_2 net1 0 tsmc18dN w=6.66u l=360.0n as=2.997e-12 ad=2.997e-12 ps=14.22u pd=14.22u m=1
  MN11 Vbias_1 Vbias_1 net2 0 tsmc18dN w=6.66u l=360.0n as=2.997e-12 ad=2.997e-12 ps=14.22u pd=14.22u m=1
  MN10 net10 Vbias_4 0 0 tsmc18dN w=6.66u l=360.0n as=2.997e-12 ad=2.997e-12 ps=14.22u pd=14.22u m=1
  MN9 Vbias_4 Vbias_3 net10 0 tsmc18dN w=6.66u l=360.0n as=2.997e-12 ad=2.997e-12 ps=14.22u pd=14.22u m=1
  MN8 Vbias_3 Vbias_3 0 0 tsmc18dN w=6.66u l=3.33u as=2.997e-12 ad=2.997e-12 ps=14.22u pd=14.22u m=1
  MN7 net2 Iin 0 0 tsmc18dN w=6.66u l=360.0n as=2.997e-12 ad=2.997e-12 ps=14.22u pd=14.22u m=1
  MN6 net1 Iin 0 0 tsmc18dN w=6.66u l=360.0n as=2.997e-12 ad=2.997e-12 ps=14.22u pd=14.22u m=1
  MN4 Iin Iin 0 0 tsmc18dN w=6.66u l=360.0n as=2.997e-12 ad=2.997e-12 ps=14.22u pd=14.22u m=1
  MP11 net6 Vbias_1 vdd vdd tsmc18dP w=12.195u l=360.0n as=5.48775e-12 ad=5.48775e-12 ps=25.29u pd=25.29u m=1
  MP10 Vbias_4 Vbias_2 net6 vdd tsmc18dP w=12.195u l=360.0n as=5.48775e-12 ad=5.48775e-12 ps=25.29u pd=25.29u m=1
  MP7 net5 Vbias_1 vdd vdd tsmc18dP w=12.195u l=360.0n as=5.48775e-12 ad=5.48775e-12 ps=25.29u pd=25.29u m=1
  MP6 Vbias_3 Vbias_2 net5 vdd tsmc18dP w=12.195u l=360.0n as=5.48775e-12 ad=5.48775e-12 ps=25.29u pd=25.29u m=1
  MP4 Vbias_2 Vbias_2 vdd vdd tsmc18dP w=12.195u l=4u as=5.48775e-12 ad=5.48775e-12 ps=25.29u pd=25.29u m=1
  MP3 net13 Vbias_1 vdd vdd tsmc18dP w=12.195u l=360.0n as=5.48775e-12 ad=5.48775e-12 ps=25.29u pd=25.29u m=1
  MP2 Vbias_1 Vbias_2 net13 vdd tsmc18dP w=12.195u l=360.0n as=5.48775e-12 ad=5.48775e-12 ps=25.29u pd=25.29u m=1
.ends Cascode_Bias_WS
.subckt OTA_Telescopic VCM Vbias_2 Vbias_3 Vbias_4 vm vout vp
  MP0 net0100 net082 vdd vdd tsmc18dP w=2.43u l=360.0n as=1.0935e-12 ad=1.0935e-12 ps=5.76u pd=5.76u m=5
  MP3 vout Vbias_2 net097 vdd tsmc18dP w=2.43u l=360.0n as=1.0935e-12 ad=1.0935e-12 ps=5.76u pd=5.76u m=5
  MP4 net016 Vbias5 vdd vdd tsmc18dP w=2.43u l=360.0n as=1.0935e-12 ad=1.0935e-12 ps=5.76u pd=5.76u m=1
  MP2 net097 net082 vdd vdd tsmc18dP w=2.43u l=360.0n as=1.0935e-12 ad=1.0935e-12 ps=5.76u pd=5.76u m=5
  MP1 net082 Vbias_2 net0100 vdd tsmc18dP w=2.43u l=360.0n as=1.0935e-12 ad=1.0935e-12 ps=5.76u pd=5.76u m=5
  MP5 Vbias5 Vbias_2 net016 vdd tsmc18dP w=2.43u l=360.0n as=1.0935e-12 ad=1.0935e-12 ps=5.76u pd=5.76u m=1
  MN11 Vbias5 Vbias5 net015 0 tsmc18dN w=1.35u l=360.0n as=6.075e-13 ad=6.075e-13 ps=3.6u pd=3.6u m=1
  MN8 net015 VCM net014 0 tsmc18dN w=1.35u l=360.0n as=6.075e-13 ad=6.075e-13 ps=3.6u pd=3.6u m=1
  MN4 net8 Vbias_3 net012 0 tsmc18dN w=1.35u l=360.0n as=6.075e-13 ad=6.075e-13 ps=3.6u pd=3.6u m=5
  MN5 net012 Vbias_4 0 0 tsmc18dN w=1.35u l=360.0n as=6.075e-13 ad=6.075e-13 ps=3.6u pd=3.6u m=5
  MN9 net014 Vbias_3 net017 0 tsmc18dN w=1.35u l=360.0n as=6.075e-13 ad=6.075e-13 ps=3.6u pd=3.6u m=1
  MN1 net074 vp net8 0 tsmc18dN w=1.35u l=360.0n as=6.075e-13 ad=6.075e-13 ps=3.6u pd=3.6u m=5
  MN6 net6 Vbias_4 0 0 tsmc18dN w=1.35u l=360.0n as=6.075e-13 ad=6.075e-13 ps=3.6u pd=3.6u m=5
  MN3 net030 vm net8 0 tsmc18dN w=1.35u l=360.0n as=6.075e-13 ad=6.075e-13 ps=3.6u pd=3.6u m=5
  MN7 net8 Vbias_3 net6 0 tsmc18dN w=1.35u l=360.0n as=6.075e-13 ad=6.075e-13 ps=3.6u pd=3.6u m=5
  MN0 net082 Vbias5 net074 0 tsmc18dN w=1.35u l=360.0n as=6.075e-13 ad=6.075e-13 ps=3.6u pd=3.6u m=5
  MN2 vout Vbias5 net030 0 tsmc18dN w=1.35u l=360.0n as=6.075e-13 ad=6.075e-13 ps=3.6u pd=3.6u m=5
  MN10 net017 Vbias_4 0 0 tsmc18dN w=1.35u l=360.0n as=6.075e-13 ad=6.075e-13 ps=3.6u pd=3.6u m=1
.ends OTA_Telescopic
.subckt dut iref inp inn out
XI0 iref vb1 vb2 vb3 vb4 Cascode_Bias_WS
* the OTA's VCM pin (replica bias of the cascode gates) is fed from an on-chip VDD/2 divider,
* which equals the testbench VCM (VDD/2) as in the advisor's testbenches (0.18 uA extra)
Rcm1 vdd vcmref 5meg
Rcm2 vcmref 0 5meg
XI1 vcmref vb2 vb3 vb4 inn out inp OTA_Telescopic
.ends dut
