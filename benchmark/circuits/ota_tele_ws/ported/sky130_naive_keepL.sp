* ota_tele_ws: NAIVE PORT (keepL) of source_180n.sp to Sky130 1.8 V LVT devices.
* Generated by benchmark/naive_port.py: device swap + length rule only; topology, m, bulks,
* R/C values unchanged. Sizes in um (Sky130 models use .option scale=1u).
* Device changes:
*   MN12: tsmc18dN W=6.66 L=0.36 -> nfet_01v8_lvt W=6.66 L=0.36 m=1
*   MN11: tsmc18dN W=6.66 L=0.36 -> nfet_01v8_lvt W=6.66 L=0.36 m=1
*   MN10: tsmc18dN W=6.66 L=0.36 -> nfet_01v8_lvt W=6.66 L=0.36 m=1
*   MN9: tsmc18dN W=6.66 L=0.36 -> nfet_01v8_lvt W=6.66 L=0.36 m=1
*   MN8: tsmc18dN W=6.66 L=3.33 -> nfet_01v8_lvt W=6.66 L=3.33 m=1
*   MN7: tsmc18dN W=6.66 L=0.36 -> nfet_01v8_lvt W=6.66 L=0.36 m=1
*   MN6: tsmc18dN W=6.66 L=0.36 -> nfet_01v8_lvt W=6.66 L=0.36 m=1
*   MN4: tsmc18dN W=6.66 L=0.36 -> nfet_01v8_lvt W=6.66 L=0.36 m=1
*   MP11: tsmc18dP W=12.195 L=0.36 -> pfet_01v8_lvt W=12.195 L=0.36 m=1
*   MP10: tsmc18dP W=12.195 L=0.36 -> pfet_01v8_lvt W=12.195 L=0.36 m=1
*   MP7: tsmc18dP W=12.195 L=0.36 -> pfet_01v8_lvt W=12.195 L=0.36 m=1
*   MP6: tsmc18dP W=12.195 L=0.36 -> pfet_01v8_lvt W=12.195 L=0.36 m=1
*   MP4: tsmc18dP W=12.195 L=4 -> pfet_01v8_lvt W=12.195 L=4 m=1
*   MP3: tsmc18dP W=12.195 L=0.36 -> pfet_01v8_lvt W=12.195 L=0.36 m=1
*   MP2: tsmc18dP W=12.195 L=0.36 -> pfet_01v8_lvt W=12.195 L=0.36 m=1
*   MP0: tsmc18dP W=2.43 L=0.36 -> pfet_01v8_lvt W=2.43 L=0.36 m=5
*   MP3: tsmc18dP W=2.43 L=0.36 -> pfet_01v8_lvt W=2.43 L=0.36 m=5
*   MP4: tsmc18dP W=2.43 L=0.36 -> pfet_01v8_lvt W=2.43 L=0.36 m=1
*   MP2: tsmc18dP W=2.43 L=0.36 -> pfet_01v8_lvt W=2.43 L=0.36 m=5
*   MP1: tsmc18dP W=2.43 L=0.36 -> pfet_01v8_lvt W=2.43 L=0.36 m=5
*   MP5: tsmc18dP W=2.43 L=0.36 -> pfet_01v8_lvt W=2.43 L=0.36 m=1
*   MN11: tsmc18dN W=1.35 L=0.36 -> nfet_01v8_lvt W=1.35 L=0.36 m=1
*   MN8: tsmc18dN W=1.35 L=0.36 -> nfet_01v8_lvt W=1.35 L=0.36 m=1
*   MN4: tsmc18dN W=1.35 L=0.36 -> nfet_01v8_lvt W=1.35 L=0.36 m=5
*   MN5: tsmc18dN W=1.35 L=0.36 -> nfet_01v8_lvt W=1.35 L=0.36 m=5
*   MN9: tsmc18dN W=1.35 L=0.36 -> nfet_01v8_lvt W=1.35 L=0.36 m=1
*   MN1: tsmc18dN W=1.35 L=0.36 -> nfet_01v8_lvt W=1.35 L=0.36 m=5
*   MN6: tsmc18dN W=1.35 L=0.36 -> nfet_01v8_lvt W=1.35 L=0.36 m=5
*   MN3: tsmc18dN W=1.35 L=0.36 -> nfet_01v8_lvt W=1.35 L=0.36 m=5
*   MN7: tsmc18dN W=1.35 L=0.36 -> nfet_01v8_lvt W=1.35 L=0.36 m=5
*   MN0: tsmc18dN W=1.35 L=0.36 -> nfet_01v8_lvt W=1.35 L=0.36 m=5
*   MN2: tsmc18dN W=1.35 L=0.36 -> nfet_01v8_lvt W=1.35 L=0.36 m=5
*   MN10: tsmc18dN W=1.35 L=0.36 -> nfet_01v8_lvt W=1.35 L=0.36 m=1
* ota_tele_ws: DUT built from ngspice-180n-testbenches/tb_OTA_Telescopic_ac/tb_OTA_Telescopic_ac.cir (advisor's design, wide-swing bias, P4 L = 4 um)
* Generated by benchmark/import_180n_sources.py; subcircuits copied verbatim.
* Single-ended telescopic OTA with replica-biased cascodes.
* Ports: iref inp inn out.
.subckt Cascode_Bias_WS Iin Vbias_1 Vbias_2 Vbias_3 Vbias_4
  XMN12 Vbias_2 Vbias_2 net1 0 sky130_fd_pr__nfet_01v8_lvt W=6.66 L=0.36 nf=1 ad=1.9314 as=1.9314 pd=13.9 ps=13.9 m=1
  XMN11 Vbias_1 Vbias_1 net2 0 sky130_fd_pr__nfet_01v8_lvt W=6.66 L=0.36 nf=1 ad=1.9314 as=1.9314 pd=13.9 ps=13.9 m=1
  XMN10 net10 Vbias_4 0 0 sky130_fd_pr__nfet_01v8_lvt W=6.66 L=0.36 nf=1 ad=1.9314 as=1.9314 pd=13.9 ps=13.9 m=1
  XMN9 Vbias_4 Vbias_3 net10 0 sky130_fd_pr__nfet_01v8_lvt W=6.66 L=0.36 nf=1 ad=1.9314 as=1.9314 pd=13.9 ps=13.9 m=1
  XMN8 Vbias_3 Vbias_3 0 0 sky130_fd_pr__nfet_01v8_lvt W=6.66 L=3.33 nf=1 ad=1.9314 as=1.9314 pd=13.9 ps=13.9 m=1
  XMN7 net2 Iin 0 0 sky130_fd_pr__nfet_01v8_lvt W=6.66 L=0.36 nf=1 ad=1.9314 as=1.9314 pd=13.9 ps=13.9 m=1
  XMN6 net1 Iin 0 0 sky130_fd_pr__nfet_01v8_lvt W=6.66 L=0.36 nf=1 ad=1.9314 as=1.9314 pd=13.9 ps=13.9 m=1
  XMN4 Iin Iin 0 0 sky130_fd_pr__nfet_01v8_lvt W=6.66 L=0.36 nf=1 ad=1.9314 as=1.9314 pd=13.9 ps=13.9 m=1
  XMP11 net6 Vbias_1 vdd vdd sky130_fd_pr__pfet_01v8_lvt W=12.195 L=0.36 nf=1 ad=3.53655 as=3.53655 pd=24.97 ps=24.97 m=1
  XMP10 Vbias_4 Vbias_2 net6 vdd sky130_fd_pr__pfet_01v8_lvt W=12.195 L=0.36 nf=1 ad=3.53655 as=3.53655 pd=24.97 ps=24.97 m=1
  XMP7 net5 Vbias_1 vdd vdd sky130_fd_pr__pfet_01v8_lvt W=12.195 L=0.36 nf=1 ad=3.53655 as=3.53655 pd=24.97 ps=24.97 m=1
  XMP6 Vbias_3 Vbias_2 net5 vdd sky130_fd_pr__pfet_01v8_lvt W=12.195 L=0.36 nf=1 ad=3.53655 as=3.53655 pd=24.97 ps=24.97 m=1
  XMP4 Vbias_2 Vbias_2 vdd vdd sky130_fd_pr__pfet_01v8_lvt W=12.195 L=4 nf=1 ad=3.53655 as=3.53655 pd=24.97 ps=24.97 m=1
  XMP3 net13 Vbias_1 vdd vdd sky130_fd_pr__pfet_01v8_lvt W=12.195 L=0.36 nf=1 ad=3.53655 as=3.53655 pd=24.97 ps=24.97 m=1
  XMP2 Vbias_1 Vbias_2 net13 vdd sky130_fd_pr__pfet_01v8_lvt W=12.195 L=0.36 nf=1 ad=3.53655 as=3.53655 pd=24.97 ps=24.97 m=1
.ends Cascode_Bias_WS
.subckt OTA_Telescopic VCM Vbias_2 Vbias_3 Vbias_4 vm vout vp
  XMP0 net0100 net082 vdd vdd sky130_fd_pr__pfet_01v8_lvt W=2.43 L=0.36 nf=1 ad=0.7047 as=0.7047 pd=5.44 ps=5.44 m=5
  XMP3 vout Vbias_2 net097 vdd sky130_fd_pr__pfet_01v8_lvt W=2.43 L=0.36 nf=1 ad=0.7047 as=0.7047 pd=5.44 ps=5.44 m=5
  XMP4 net016 Vbias5 vdd vdd sky130_fd_pr__pfet_01v8_lvt W=2.43 L=0.36 nf=1 ad=0.7047 as=0.7047 pd=5.44 ps=5.44 m=1
  XMP2 net097 net082 vdd vdd sky130_fd_pr__pfet_01v8_lvt W=2.43 L=0.36 nf=1 ad=0.7047 as=0.7047 pd=5.44 ps=5.44 m=5
  XMP1 net082 Vbias_2 net0100 vdd sky130_fd_pr__pfet_01v8_lvt W=2.43 L=0.36 nf=1 ad=0.7047 as=0.7047 pd=5.44 ps=5.44 m=5
  XMP5 Vbias5 Vbias_2 net016 vdd sky130_fd_pr__pfet_01v8_lvt W=2.43 L=0.36 nf=1 ad=0.7047 as=0.7047 pd=5.44 ps=5.44 m=1
  XMN11 Vbias5 Vbias5 net015 0 sky130_fd_pr__nfet_01v8_lvt W=1.35 L=0.36 nf=1 ad=0.3915 as=0.3915 pd=3.28 ps=3.28 m=1
  XMN8 net015 VCM net014 0 sky130_fd_pr__nfet_01v8_lvt W=1.35 L=0.36 nf=1 ad=0.3915 as=0.3915 pd=3.28 ps=3.28 m=1
  XMN4 net8 Vbias_3 net012 0 sky130_fd_pr__nfet_01v8_lvt W=1.35 L=0.36 nf=1 ad=0.3915 as=0.3915 pd=3.28 ps=3.28 m=5
  XMN5 net012 Vbias_4 0 0 sky130_fd_pr__nfet_01v8_lvt W=1.35 L=0.36 nf=1 ad=0.3915 as=0.3915 pd=3.28 ps=3.28 m=5
  XMN9 net014 Vbias_3 net017 0 sky130_fd_pr__nfet_01v8_lvt W=1.35 L=0.36 nf=1 ad=0.3915 as=0.3915 pd=3.28 ps=3.28 m=1
  XMN1 net074 vp net8 0 sky130_fd_pr__nfet_01v8_lvt W=1.35 L=0.36 nf=1 ad=0.3915 as=0.3915 pd=3.28 ps=3.28 m=5
  XMN6 net6 Vbias_4 0 0 sky130_fd_pr__nfet_01v8_lvt W=1.35 L=0.36 nf=1 ad=0.3915 as=0.3915 pd=3.28 ps=3.28 m=5
  XMN3 net030 vm net8 0 sky130_fd_pr__nfet_01v8_lvt W=1.35 L=0.36 nf=1 ad=0.3915 as=0.3915 pd=3.28 ps=3.28 m=5
  XMN7 net8 Vbias_3 net6 0 sky130_fd_pr__nfet_01v8_lvt W=1.35 L=0.36 nf=1 ad=0.3915 as=0.3915 pd=3.28 ps=3.28 m=5
  XMN0 net082 Vbias5 net074 0 sky130_fd_pr__nfet_01v8_lvt W=1.35 L=0.36 nf=1 ad=0.3915 as=0.3915 pd=3.28 ps=3.28 m=5
  XMN2 vout Vbias5 net030 0 sky130_fd_pr__nfet_01v8_lvt W=1.35 L=0.36 nf=1 ad=0.3915 as=0.3915 pd=3.28 ps=3.28 m=5
  XMN10 net017 Vbias_4 0 0 sky130_fd_pr__nfet_01v8_lvt W=1.35 L=0.36 nf=1 ad=0.3915 as=0.3915 pd=3.28 ps=3.28 m=1
.ends OTA_Telescopic
.subckt dut iref inp inn out
XI0 iref vb1 vb2 vb3 vb4 Cascode_Bias_WS
* the OTA's VCM pin (replica bias of the cascode gates) is fed from an on-chip VDD/2 divider,
* which equals the testbench VCM (VDD/2) as in the advisor's testbenches (0.18 uA extra)
Rcm1 vdd vcmref 5meg
Rcm2 vcmref 0 5meg
XI1 vcmref vb2 vb3 vb4 inn out inp OTA_Telescopic
.ends dut
