* ota_tele: NAIVE PORT (keepL) of source_180n.sp to Sky130 1.8 V LVT devices.
* Generated by benchmark/naive_port.py: device swap + length rule only; topology, m, bulks,
* R/C values unchanged. Sizes in um (Sky130 models use .option scale=1u).
* Device changes:
*   MB1: tsmc18dN W=6.66 L=0.36 -> nfet_01v8_lvt W=6.66 L=0.36 m=1
*   MB2: tsmc18dN W=1.5 L=0.36 -> nfet_01v8_lvt W=1.5 L=0.36 m=1
*   MB3: tsmc18dN W=6.66 L=0.36 -> nfet_01v8_lvt W=6.66 L=0.36 m=1
*   MB4: tsmc18dP W=12.195 L=0.36 -> pfet_01v8_lvt W=12.195 L=0.36 m=1
*   MB5: tsmc18dP W=12.195 L=0.36 -> pfet_01v8_lvt W=12.195 L=0.36 m=1
*   MB6: tsmc18dN W=6.66 L=0.36 -> nfet_01v8_lvt W=6.66 L=0.36 m=1
*   MB7: tsmc18dP W=1.2 L=0.36 -> pfet_01v8_lvt W=1.2 L=0.36 m=1
*   MB8: tsmc18dN W=6.66 L=0.36 -> nfet_01v8_lvt W=6.66 L=0.36 m=1
*   MT: tsmc18dN W=6.66 L=0.36 -> nfet_01v8_lvt W=6.66 L=0.36 m=2
*   M1: tsmc18dN W=10 L=0.36 -> nfet_01v8_lvt W=10 L=0.36 m=1
*   M2: tsmc18dN W=10 L=0.36 -> nfet_01v8_lvt W=10 L=0.36 m=1
*   M3: tsmc18dN W=10 L=0.5 -> nfet_01v8_lvt W=10 L=0.5 m=1
*   M4: tsmc18dN W=10 L=0.5 -> nfet_01v8_lvt W=10 L=0.5 m=1
*   M5: tsmc18dP W=12.195 L=0.5 -> pfet_01v8_lvt W=12.195 L=0.5 m=1
*   M6: tsmc18dP W=12.195 L=0.5 -> pfet_01v8_lvt W=12.195 L=0.5 m=1
*   M7: tsmc18dP W=12.195 L=0.5 -> pfet_01v8_lvt W=12.195 L=0.5 m=1
*   M8: tsmc18dP W=12.195 L=0.5 -> pfet_01v8_lvt W=12.195 L=0.5 m=1
* ota_tele: single-ended telescopic cascode OTA (new circuit, not from ngspice-180n-testbenches)
* Source design written for this benchmark; pending review by a designer.
* Ports: iref (20 uA bias current in), inp, inn, out. Tail current 40 uA (2 x Iref).
* Stack from vdd to ground: PMOS load, PMOS cascode, NMOS cascode, NMOS input, NMOS tail (5 devices).
.subckt dut iref inp inn out
* --- bias: NMOS reference diode (vbn), NMOS cascode gate vcn (two stacked diodes, ~2 Vgs),
*     PMOS cascode gate vcp (weak PMOS diode fed by an NMOS copy of Iref)
XMB1 iref iref 0 0 sky130_fd_pr__nfet_01v8_lvt W=6.66 L=0.36 nf=1 ad=1.9314 as=1.9314 pd=13.9 ps=13.9 m=1
XMB2 vcn vcn nb2 0 sky130_fd_pr__nfet_01v8_lvt W=1.5 L=0.36 nf=1 ad=0.435 as=0.435 pd=3.58 ps=3.58 m=1
XMB3 nb2 nb2 0 0 sky130_fd_pr__nfet_01v8_lvt W=6.66 L=0.36 nf=1 ad=1.9314 as=1.9314 pd=13.9 ps=13.9 m=1
XMB4 vcn vcpref vdd vdd sky130_fd_pr__pfet_01v8_lvt W=12.195 L=0.36 nf=1 ad=3.53655 as=3.53655 pd=24.97 ps=24.97 m=1
XMB5 vcpref vcpref vdd vdd sky130_fd_pr__pfet_01v8_lvt W=12.195 L=0.36 nf=1 ad=3.53655 as=3.53655 pd=24.97 ps=24.97 m=1
XMB6 vcpref iref 0 0 sky130_fd_pr__nfet_01v8_lvt W=6.66 L=0.36 nf=1 ad=1.9314 as=1.9314 pd=13.9 ps=13.9 m=1
XMB7 vcp vcp vdd vdd sky130_fd_pr__pfet_01v8_lvt W=1.2 L=0.36 nf=1 ad=0.348 as=0.348 pd=2.98 ps=2.98 m=1
XMB8 vcp iref 0 0 sky130_fd_pr__nfet_01v8_lvt W=6.66 L=0.36 nf=1 ad=1.9314 as=1.9314 pd=13.9 ps=13.9 m=1
* --- tail
XMT tail iref 0 0 sky130_fd_pr__nfet_01v8_lvt W=6.66 L=0.36 nf=1 ad=1.9314 as=1.9314 pd=13.9 ps=13.9 m=2
* --- input pair and NMOS cascodes
XM1 x1 inp tail 0 sky130_fd_pr__nfet_01v8_lvt W=10 L=0.36 nf=1 ad=2.9 as=2.9 pd=20.58 ps=20.58 m=1
XM2 x2 inn tail 0 sky130_fd_pr__nfet_01v8_lvt W=10 L=0.36 nf=1 ad=2.9 as=2.9 pd=20.58 ps=20.58 m=1
XM3 d1 vcn x1 0 sky130_fd_pr__nfet_01v8_lvt W=10 L=0.5 nf=1 ad=2.9 as=2.9 pd=20.58 ps=20.58 m=1
XM4 out vcn x2 0 sky130_fd_pr__nfet_01v8_lvt W=10 L=0.5 nf=1 ad=2.9 as=2.9 pd=20.58 ps=20.58 m=1
* --- PMOS low-voltage cascode mirror load (diode side at d1)
XM5 d1 vcp y1 vdd sky130_fd_pr__pfet_01v8_lvt W=12.195 L=0.5 nf=1 ad=3.53655 as=3.53655 pd=24.97 ps=24.97 m=1
XM6 out vcp y2 vdd sky130_fd_pr__pfet_01v8_lvt W=12.195 L=0.5 nf=1 ad=3.53655 as=3.53655 pd=24.97 ps=24.97 m=1
XM7 y1 d1 vdd vdd sky130_fd_pr__pfet_01v8_lvt W=12.195 L=0.5 nf=1 ad=3.53655 as=3.53655 pd=24.97 ps=24.97 m=1
XM8 y2 d1 vdd vdd sky130_fd_pr__pfet_01v8_lvt W=12.195 L=0.5 nf=1 ad=3.53655 as=3.53655 pd=24.97 ps=24.97 m=1
.ends dut
