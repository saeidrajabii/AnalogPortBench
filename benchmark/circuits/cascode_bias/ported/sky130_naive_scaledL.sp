* cascode_bias: NAIVE PORT (scaledL) of source_180n.sp to Sky130 1.8 V LVT devices.
* Generated by benchmark/naive_port.py: device swap + length rule only; topology, m, bulks,
* R/C values unchanged. Sizes in um (Sky130 models use .option scale=1u).
* Device changes:
*   MN1: tsmc18dN W=6.66 L=0.36 -> nfet_01v8_lvt W=5.55 L=0.3 m=1
*   MN0: tsmc18dN W=6.66 L=0.36 -> nfet_01v8_lvt W=5.55 L=0.3 m=1
*   MN3: tsmc18dN W=6.66 L=0.36 -> nfet_01v8_lvt W=5.55 L=0.3 m=1
*   MN2: tsmc18dN W=6.66 L=0.36 -> nfet_01v8_lvt W=5.55 L=0.3 m=1
*   MP1: tsmc18dP W=12.195 L=0.36 -> pfet_01v8_lvt W=10.16 L=0.35 (clamped to Lmin) m=1
*   MP0: tsmc18dP W=12.195 L=0.36 -> pfet_01v8_lvt W=10.16 L=0.35 (clamped to Lmin) m=1
*   MN0: tsmc18dN W=6.66 L=0.36 -> nfet_01v8_lvt W=5.55 L=0.3 m=1
*   MN2: tsmc18dN W=6.66 L=0.36 -> nfet_01v8_lvt W=5.55 L=0.3 m=1
*   MP1: tsmc18dP W=12.195 L=0.36 -> pfet_01v8_lvt W=10.16 L=0.35 (clamped to Lmin) m=1
*   MP0: tsmc18dP W=12.195 L=0.36 -> pfet_01v8_lvt W=10.16 L=0.35 (clamped to Lmin) m=1
* cascode_bias: DUT extracted from ngspice-180n-testbenches/tb_Cascode_Bias/tb_Cascode_Bias.cir
* Ports: iin (Iref in), out (node between the PMOS cascode source and NMOS cascode sink), vb1..vb4.
* NOTE: in this testbench MN3/MN2 inside Cascode_Bias have source-tied bulks; the copies inside the
* OTA testbenches tie them to 0 (see AUDIT.md).
.subckt Cascode_Bias Iin Vbias_1 Vbias_2 Vbias_3 Vbias_4
  XMN1 Vbias_4 Vbias_4 0 0 sky130_fd_pr__nfet_01v8_lvt W=5.55 L=0.3 nf=1 ad=1.6095 as=1.6095 pd=11.68 ps=11.68 m=1
  XMN0 net4 Vbias_4 0 0 sky130_fd_pr__nfet_01v8_lvt W=5.55 L=0.3 nf=1 ad=1.6095 as=1.6095 pd=11.68 ps=11.68 m=1
  XMN3 Vbias_3 Vbias_3 Vbias_4 Vbias_4 sky130_fd_pr__nfet_01v8_lvt W=5.55 L=0.3 nf=1 ad=1.6095 as=1.6095 pd=11.68 ps=11.68 m=1
  XMN2 Vbias_2 Vbias_3 net4 net4 sky130_fd_pr__nfet_01v8_lvt W=5.55 L=0.3 nf=1 ad=1.6095 as=1.6095 pd=11.68 ps=11.68 m=1
  XMP1 Vbias_1 Vbias_1 vdd vdd sky130_fd_pr__pfet_01v8_lvt W=10.16 L=0.35 nf=1 ad=2.9464 as=2.9464 pd=20.9 ps=20.9 m=1
  XMP0 Vbias_2 Vbias_2 Vbias_1 vdd sky130_fd_pr__pfet_01v8_lvt W=10.16 L=0.35 nf=1 ad=2.9464 as=2.9464 pd=20.9 ps=20.9 m=1
  RR0 Iin Vbias_3 1
.ends Cascode_Bias
.subckt dut iin out vb1 vb2 vb3 vb4
XI0 iin vb1 vb2 vb3 vb4 Cascode_Bias
XMN0 nsrc vb4 0 0 sky130_fd_pr__nfet_01v8_lvt W=5.55 L=0.3 nf=1 ad=1.6095 as=1.6095 pd=11.68 ps=11.68 m=1
XMN2 out vb3 nsrc 0 sky130_fd_pr__nfet_01v8_lvt W=5.55 L=0.3 nf=1 ad=1.6095 as=1.6095 pd=11.68 ps=11.68 m=1
XMP1 psrc vb1 vdd vdd sky130_fd_pr__pfet_01v8_lvt W=10.16 L=0.35 nf=1 ad=2.9464 as=2.9464 pd=20.9 ps=20.9 m=1
XMP0 out vb2 psrc vdd sky130_fd_pr__pfet_01v8_lvt W=10.16 L=0.35 nf=1 ad=2.9464 as=2.9464 pd=20.9 ps=20.9 m=1
.ends dut
