* cascode_bias_ws: NAIVE PORT (keepL) of source_180n.sp to Sky130 1.8 V LVT devices.
* Generated by benchmark/naive_port.py: device swap + length rule only; topology, m, bulks,
* R/C values unchanged. Sizes in um (Sky130 models use .option scale=1u).
* Device changes:
*   MN12: tsmc18dN W=6.66 L=0.36 -> nfet_01v8_lvt W=6.66 L=0.36 m=1
*   MN11: tsmc18dN W=6.66 L=0.36 -> nfet_01v8_lvt W=6.66 L=0.36 m=1
*   MN10: tsmc18dN W=6.66 L=0.36 -> nfet_01v8_lvt W=6.66 L=0.36 m=1
*   MN9: tsmc18dN W=6.66 L=0.36 -> nfet_01v8_lvt W=6.66 L=0.36 m=1
*   MN8: tsmc18dN W=6.66 L=3.33 -> nfet_01v8_lvt W=6.66 L=3.33 m=1
*   MN7: tsmc18dN W=6.66 L=0.36 -> nfet_01v8_lvt W=6.66 L=0.36 m=1
*   MN6: tsmc18dN W=6.66 L=0.36 -> nfet_01v8_lvt W=6.66 L=0.36 m=1
*   MN4: tsmc18dN W=6.66 L=0.36 -> nfet_01v8_lvt W=6.66 L=0.36 m=1
*   MP11: tsmc18dP W=12.195 L=0.36 -> pfet_01v8_lvt W=12.195 L=0.36 m=1
*   MP10: tsmc18dP W=12.195 L=0.36 -> pfet_01v8_lvt W=12.195 L=0.36 m=1
*   MP7: tsmc18dP W=12.195 L=0.36 -> pfet_01v8_lvt W=12.195 L=0.36 m=1
*   MP6: tsmc18dP W=12.195 L=0.36 -> pfet_01v8_lvt W=12.195 L=0.36 m=1
*   MP4: tsmc18dP W=12.195 L=4 -> pfet_01v8_lvt W=12.195 L=4 m=1
*   MP3: tsmc18dP W=12.195 L=0.36 -> pfet_01v8_lvt W=12.195 L=0.36 m=1
*   MP2: tsmc18dP W=12.195 L=0.36 -> pfet_01v8_lvt W=12.195 L=0.36 m=1
*   MN0: tsmc18dN W=6.66 L=0.36 -> nfet_01v8_lvt W=6.66 L=0.36 m=1
*   MN2: tsmc18dN W=6.66 L=0.36 -> nfet_01v8_lvt W=6.66 L=0.36 m=1
*   MP1: tsmc18dP W=12.195 L=0.36 -> pfet_01v8_lvt W=12.195 L=0.36 m=1
*   MP0: tsmc18dP W=12.195 L=0.36 -> pfet_01v8_lvt W=12.195 L=0.36 m=1
* cascode_bias_ws: DUT built from ngspice-180n-testbenches/tb_Cascode_Bias_WS/tb_Cascode_Bias_WS.cir (advisor's design, wide-swing bias, P4 L = 4 um)
* Generated by benchmark/import_180n_sources.py; subcircuits copied verbatim.
* Wide-swing cascode bias generator driving a PMOS cascode source and an NMOS cascode sink.
* Ports: iin out vb1 vb2 vb3 vb4.
.subckt Cascode_Bias_WS Iin Vbias_1 Vbias_2 Vbias_3 Vbias_4
  XMN12 Vbias_2 Vbias_2 net1 0 sky130_fd_pr__nfet_01v8_lvt W=6.66 L=0.36 nf=1 ad=1.9314 as=1.9314 pd=13.9 ps=13.9 m=1
  XMN11 Vbias_1 Vbias_1 net2 0 sky130_fd_pr__nfet_01v8_lvt W=6.66 L=0.36 nf=1 ad=1.9314 as=1.9314 pd=13.9 ps=13.9 m=1
  XMN10 net10 Vbias_4 0 0 sky130_fd_pr__nfet_01v8_lvt W=6.66 L=0.36 nf=1 ad=1.9314 as=1.9314 pd=13.9 ps=13.9 m=1
  XMN9 Vbias_4 Vbias_3 net10 0 sky130_fd_pr__nfet_01v8_lvt W=6.66 L=0.36 nf=1 ad=1.9314 as=1.9314 pd=13.9 ps=13.9 m=1
  XMN8 Vbias_3 Vbias_3 0 0 sky130_fd_pr__nfet_01v8_lvt W=6.66 L=3.33 nf=1 ad=1.9314 as=1.9314 pd=13.9 ps=13.9 m=1
  XMN7 net2 Iin 0 0 sky130_fd_pr__nfet_01v8_lvt W=6.66 L=0.36 nf=1 ad=1.9314 as=1.9314 pd=13.9 ps=13.9 m=1
  XMN6 net1 Iin 0 0 sky130_fd_pr__nfet_01v8_lvt W=6.66 L=0.36 nf=1 ad=1.9314 as=1.9314 pd=13.9 ps=13.9 m=1
  XMN4 Iin Iin 0 0 sky130_fd_pr__nfet_01v8_lvt W=6.66 L=0.36 nf=1 ad=1.9314 as=1.9314 pd=13.9 ps=13.9 m=1
  XMP11 net6 Vbias_1 vdd vdd sky130_fd_pr__pfet_01v8_lvt W=12.195 L=0.36 nf=1 ad=3.53655 as=3.53655 pd=24.97 ps=24.97 m=1
  XMP10 Vbias_4 Vbias_2 net6 vdd sky130_fd_pr__pfet_01v8_lvt W=12.195 L=0.36 nf=1 ad=3.53655 as=3.53655 pd=24.97 ps=24.97 m=1
  XMP7 net5 Vbias_1 vdd vdd sky130_fd_pr__pfet_01v8_lvt W=12.195 L=0.36 nf=1 ad=3.53655 as=3.53655 pd=24.97 ps=24.97 m=1
  XMP6 Vbias_3 Vbias_2 net5 vdd sky130_fd_pr__pfet_01v8_lvt W=12.195 L=0.36 nf=1 ad=3.53655 as=3.53655 pd=24.97 ps=24.97 m=1
  XMP4 Vbias_2 Vbias_2 vdd vdd sky130_fd_pr__pfet_01v8_lvt W=12.195 L=4 nf=1 ad=3.53655 as=3.53655 pd=24.97 ps=24.97 m=1
  XMP3 net13 Vbias_1 vdd vdd sky130_fd_pr__pfet_01v8_lvt W=12.195 L=0.36 nf=1 ad=3.53655 as=3.53655 pd=24.97 ps=24.97 m=1
  XMP2 Vbias_1 Vbias_2 net13 vdd sky130_fd_pr__pfet_01v8_lvt W=12.195 L=0.36 nf=1 ad=3.53655 as=3.53655 pd=24.97 ps=24.97 m=1
.ends Cascode_Bias_WS
.subckt dut iin out vb1 vb2 vb3 vb4
XI0 iin vb1 vb2 vb3 vb4 Cascode_Bias_WS
XMN0 nsrc vb4 0 0 sky130_fd_pr__nfet_01v8_lvt W=6.66 L=0.36 nf=1 ad=1.9314 as=1.9314 pd=13.9 ps=13.9 m=1
XMN2 out vb3 nsrc 0 sky130_fd_pr__nfet_01v8_lvt W=6.66 L=0.36 nf=1 ad=1.9314 as=1.9314 pd=13.9 ps=13.9 m=1
XMP1 psrc vb1 vdd vdd sky130_fd_pr__pfet_01v8_lvt W=12.195 L=0.36 nf=1 ad=3.53655 as=3.53655 pd=24.97 ps=24.97 m=1
XMP0 out vb2 psrc vdd sky130_fd_pr__pfet_01v8_lvt W=12.195 L=0.36 nf=1 ad=3.53655 as=3.53655 pd=24.97 ps=24.97 m=1
.ends dut
