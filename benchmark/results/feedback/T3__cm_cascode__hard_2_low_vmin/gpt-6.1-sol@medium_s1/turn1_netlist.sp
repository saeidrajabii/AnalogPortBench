.subckt dut in out
XMNREF in in 0 0 sky130_fd_pr__nfet_01v8_lvt W=1000 L=100 nf=1 m=1000
XMNOUT out in 0 0 sky130_fd_pr__nfet_01v8_lvt W=1000 L=100 nf=1 m=1000
.ends dut
