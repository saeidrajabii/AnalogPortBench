.subckt dut in out
XMREF in  in  vdd vdd sky130_fd_pr__pfet_01v8_lvt W=100 L=5 nf=1 m=10
XMOUT out in  vdd vdd sky130_fd_pr__pfet_01v8_lvt W=100 L=5 nf=1 m=10
.ends dut
