.subckt dut iin out vb1 vb2 vb3 vb4
* No validated SKY130 sizing can be inferred from the supplied information.
.ends dut
