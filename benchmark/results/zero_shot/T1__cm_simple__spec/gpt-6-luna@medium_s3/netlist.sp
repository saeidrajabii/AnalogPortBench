.subckt dut in out
XM1 in  in  0 0 sky130_fd_pr__nfet_01v8_lvt W=20.0 L=2.0 nf=1 m=1
XM0 out in  0 0 sky130_fd_pr__nfet_01v8_lvt W=20.0 L=2.0 nf=1 m=1
.ends dut
