.subckt dut in out
XMin  in  in  0 0 sky130_fd_pr__nfet_01v8_lvt W=1000 L=10 nf=1 m=10
XMout out in  0 0 sky130_fd_pr__nfet_01v8_lvt W=997  L=10 nf=1 m=10
.ends dut
