.subckt dut in out
* Reference and output devices use equal source-sense resistors.
RREF sref 0 1k
ROUT sout 0 1k
XREF in in sref 0 sky130_fd_pr__nfet_01v8_lvt W=60 L=0.5 nf=1 m=1
XOUT out vgout sout 0 sky130_fd_pr__nfet_01v8_lvt W=60 L=0.5 nf=1 m=1

* Bias generated by mirroring the reference transistor's gate bias.
XBIASN pbias in 0 0 sky130_fd_pr__nfet_01v8_lvt W=2 L=1 nf=1 m=1
XBIASP pbias pbias vdd vdd sky130_fd_pr__pfet_01v8_lvt W=2 L=3 nf=1 m=1

* Feedback amplifier compares the two sense-resistor voltages.
XTAIL ptail pbias vdd vdd sky130_fd_pr__pfet_01v8_lvt W=2 L=3 nf=1 m=1
XP1 a sout ptail vdd sky130_fd_pr__pfet_01v8_lvt W=4 L=2 nf=1 m=1
XP2 b sref ptail vdd sky130_fd_pr__pfet_01v8_lvt W=4 L=2 nf=1 m=1
XN1 a a 0 0 sky130_fd_pr__nfet_01v8_lvt W=2 L=3 nf=1 m=1
XN2 b a 0 0 sky130_fd_pr__nfet_01v8_lvt W=2 L=3 nf=1 m=1

* Second gain stage drives the output transistor's gate.
XP3 vgout pbias vdd vdd sky130_fd_pr__pfet_01v8_lvt W=1 L=3 nf=1 m=1
XN3 vgout b 0 0 sky130_fd_pr__nfet_01v8_lvt W=2 L=3 nf=1 m=1
.ends dut
