.subckt dut iin out vb1 vb2 vb3 vb4
* A verified port cannot be specified from the information provided:
* the SKY130 device models and their operating-point behavior are not given.
.ends dut
