.subckt dut in out
XMR in in 0 0 sky130_fd_pr__nfet_01v8_lvt W=400000 L=1000 nf=1 m=1
XMO out in 0 0 sky130_fd_pr__nfet_01v8_lvt W=400000 L=1000 nf=1 m=1
.ends dut
