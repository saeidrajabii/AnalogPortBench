* A reliable port cannot be specified from the information provided.
* In particular, the SKY130 device models and simulated results are needed to
* verify the current-match, output-range, and saturation requirements.
.subckt dut iin out vb1 vb2 vb3 vb4
.ends dut
