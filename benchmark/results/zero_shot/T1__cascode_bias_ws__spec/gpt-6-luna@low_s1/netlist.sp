.subckt dut iin out vb1 vb2 vb3 vb4
* The SKY130 model parameters are required to verify current matching,
* output swing, and the operating-region constraint.
.ends dut
