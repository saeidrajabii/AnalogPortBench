.subckt dut in out
XMN_REF in in 0 0 sky130_fd_pr__nfet_01v8_lvt W=1000 L=1000 nf=1 m=2000
XMN_OUT out in 0 0 sky130_fd_pr__nfet_01v8_lvt W=1000 L=1000 nf=1 m=2000
.ends dut
