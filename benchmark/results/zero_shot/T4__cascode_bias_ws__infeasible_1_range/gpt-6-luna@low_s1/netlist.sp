.subckt dut iin out vb1 vb2 vb3 vb4
* The given constraints do not determine a bias network or device sizes
* that can be verified to meet the current-match and saturation limits.
.ends dut
