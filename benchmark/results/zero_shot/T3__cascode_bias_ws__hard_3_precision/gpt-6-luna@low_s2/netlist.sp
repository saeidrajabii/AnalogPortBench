.subckt dut iin out vb1 vb2 vb3 vb4
* A compliant port cannot be determined from the supplied information.
.ends dut
