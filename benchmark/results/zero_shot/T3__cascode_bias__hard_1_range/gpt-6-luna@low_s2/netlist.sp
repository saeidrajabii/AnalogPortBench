.subckt dut iin out vb1 vb2 vb3 vb4
* A numerical port cannot be certified from the supplied information: the
* SKY130 model subcircuits and their TT operating-point characteristics are
* not provided. Device sizing alone cannot establish the specified current
* errors, mismatch range, or Vdsat-based triode count.
.ends dut
