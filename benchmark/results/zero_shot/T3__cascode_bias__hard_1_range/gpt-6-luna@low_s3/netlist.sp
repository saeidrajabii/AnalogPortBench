.subckt dut iin out vb1 vb2 vb3 vb4
* A model-verified port cannot be specified from the information provided.
.ends dut
