.subckt dut iref inp inn out
* Bias: iref drives an NMOS diode (MBref, ~0.85 V gate for the NMOS cascodes).
* PMOS cascode gate (vbp ~0.35 V) and tail gate (vt ~0.48 V) are generated by
* mirroring 20 uA into diode-connected devices.
XMBref   iref iref 0    0 sky130_fd_pr__nfet_01v8_lvt W=0.42 L=0.5  nf=1 m=1
XMBs1    pg   iref 0    0 sky130_fd_pr__nfet_01v8_lvt W=0.42 L=0.5  nf=1 m=1
XMBs2    vbp  iref 0    0 sky130_fd_pr__nfet_01v8_lvt W=0.42 L=0.5  nf=1 m=1
XMBpd1   pg   pg   vdd  vdd sky130_fd_pr__pfet_01v8_lvt W=6.25 L=0.5  nf=1 m=1
XMBpm    vt   pg   vdd  vdd sky130_fd_pr__pfet_01v8_lvt W=6.25 L=0.5  nf=1 m=1
XMBtd    vt   vt   0    0 sky130_fd_pr__nfet_01v8_lvt W=6.65 L=0.5  nf=1 m=1
XMBpd2   vbp  vbp  vdd  vdd sky130_fd_pr__pfet_01v8_lvt W=1.25 L=0.5  nf=1 m=1

* Telescopic OTA core
* Tail current source, about 100 uA
XMNtail  tl   vt   0    0 sky130_fd_pr__nfet_01v8_lvt W=33   L=0.5  nf=1 m=1
* Input pair (inp on the left branch, inn on the right branch)
XMN1     net074 inp  tl   0 sky130_fd_pr__nfet_01v8_lvt W=20   L=0.5  nf=1 m=1
XMN3     net030 inn  tl   0 sky130_fd_pr__nfet_01v8_lvt W=20   L=0.5  nf=1 m=1
* NMOS cascodes (gate = iref, about 0.85 V)
XMN0     net082 iref net074 0 sky130_fd_pr__nfet_01v8_lvt W=11.5 L=0.5 nf=1 m=1
XMN2     out    iref net030 0 sky130_fd_pr__nfet_01v8_lvt W=11.5 L=0.5 nf=1 m=1
* PMOS mirror load: left branch is diode-connected via the cascode at net082
XMP0     net0100 net082 vdd vdd sky130_fd_pr__pfet_01v8_lvt W=15.5 L=0.5 nf=1 m=1
XMP1     net082  vbp    net0100 vdd sky130_fd_pr__pfet_01v8_lvt W=15.5 L=0.5 nf=1 m=1
XMP2     net097 net082 vdd vdd sky130_fd_pr__pfet_01v8_lvt W=15.5 L=0.5 nf=1 m=1
XMP3     out    vbp    net097 vdd sky130_fd_pr__pfet_01v8_lvt W=15.5 L=0.5 nf=1 m=1
.ends dut
